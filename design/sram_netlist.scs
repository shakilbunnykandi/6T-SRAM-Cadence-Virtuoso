// Design: connectLib/sram
simulator lang=spectre
global 0
include "/home/install/FOUNDRY/analog/45nm/gpdk045/../models/spectre/gpdk045.scs" section=mc

// connectLib/sram/schematic
NM4 (BL WL Q 0) g45n1svt w=(120n) l=45n nf=1 m=(1)
NM2 (Qb WL BLbar 0) g45n1svt w=(120n) l=45n nf=1 m=(1)
NM1 (Qb Q 0 0) g45n1svt w=(120n) l=45n nf=1 m=(1)
NM0 (Q Qb 0 0) g45n1svt w=(120n) l=45n nf=1 m=(1)
PM1 (Qb Q net1 net1) g45p1svt w=(120n) l=45n nf=1 m=(1)
PM0 (Q Qb net1 net1) g45p1svt w=(120n) l=45n nf=1 m=(1)
V1 (Qb 0) vsource dc=1.8 type=dc
V0 (net1 0) vsource dc=1.8 type=dc
V4 (BL 0) vsource type=pulse val0=0 val1=1.8 period=2u
V3 (WL 0) vsource type=pulse val0=0 val1=1.8 period=4u
V2 (BLbar 0) vsource type=pulse val0=1.8 val1=0 period=2u
simulatorOptions options temp=27
dcOp dc
